10 V equal resistor divider operating-point smoke fixture
V1 in 0 DC 10
R1 in out 1k
R2 out 0 1k
.control
op
print v(out)
quit
.endc
.end
